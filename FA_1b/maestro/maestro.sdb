ADE simulation setup
Run mode: Single Run, Sweeps and Corners
Tests:
  ee477FinalProject_FA_1b_1: ee477FinalProject/FA_1b/schematic, simulator spectre
    Outputs: /A; /B; /C_IN; /S; /C_OUT
