ADE simulation setup
Run mode: Single Run, Sweeps and Corners
Tests:
  ee477FinalProject_testbench_MULT_1: ee477FinalProject/testbench_MULT/schematic, simulator spectre
    Outputs: /X0; /X1; /X2; /X3; /X4; /X5; /Y0; /Y1; /Y2; /Y3; /Y4; /Y5; /Q0; /Q1; /Q2; /Q3; /Q4; /Q5; /Q6; /Q7; /Q8; /Q9; /Q10; /Q11
