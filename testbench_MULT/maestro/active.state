ADE simulation setup
Test ee477FinalProject_testbench_MULT_1: ee477FinalProject/testbench_MULT/schematic, simulator spectre
  Models: /home/viterbi/01/ee577/CDS_GPDK45/gpdk045_v_5_0/gpdk045/../models/spectre/gpdk045.scs[mc]
  Temperature: 27
  Stimulus vdd!: voltage dc dc=1
  Stimulus X0: voltage pulse val0=0 val1=1 period=8n rise=10p fall=10p width=4n
  Stimulus X1: voltage pulse val0=1 val1=0 period=8n rise=10p fall=10p width=4n
  Stimulus X2: voltage pulse val0=0 val1=1 period=8n rise=10p fall=10p width=4n
  Stimulus X3: voltage pulse val0=1 val1=0 period=8n rise=10p fall=10p width=4n
  Stimulus X4: voltage pulse val0=1 val1=0 period=8n rise=10p fall=10p width=4n
  Stimulus X5: voltage pulse val0=1 val1=0 period=8n rise=10p fall=10p width=4n
  Stimulus Y0: voltage pulse val0=0 val1=1 period=8n rise=10p fall=10p width=4n
  Stimulus Y1: voltage pulse val0=0 val1=1 period=8n rise=10p fall=10p width=4n
  Stimulus Y2: voltage pulse val0=0 val1=1 period=8n rise=10p fall=10p width=4n
  Stimulus Y3: voltage pulse val0=0 val1=1 period=8n rise=10p fall=10p width=4n
  Stimulus Y4: voltage pulse val0=0 val1=1 period=8n rise=10p fall=10p width=4n
  Stimulus Y5: voltage pulse val0=0 val1=1 period=8n rise=10p fall=10p width=4n
  Analysis tran: stop=10n
  Signals: /X0, /X1, /X2, /X3, /X4, /X5, /Y0, /Y1, /Y2, /Y3, /Y4, /Y5, /Q0, /Q1, /Q2, /Q3, /Q4, /Q5, /Q6, /Q7, /Q8, /Q9, /Q10, /Q11
Run mode: Single Run, Sweeps and Corners
