ADE simulation setup
Test ee477FinalProject_AND_1X_1: ee477FinalProject/AND_1X/schematic, simulator spectre
  Models: /home/viterbi/01/ee577/CDS_GPDK45/gpdk045_v_5_0/gpdk045/../models/spectre/gpdk045.scs[mc]
  Temperature: 27
  Stimulus A: voltage pulse val0=1 val1=0 period=2n rise=10p fall=10p width=1n
  Stimulus B: voltage pulse val0=1 val1=0 period=4n rise=10p fall=10p width=2n
  Stimulus vdd!: voltage dc dc=1
  Analysis tran: stop=10n
  Signals: /A, /B, /OUT
Run mode: Single Run, Sweeps and Corners
