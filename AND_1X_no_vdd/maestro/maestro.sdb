ADE simulation setup
Run mode: Single Run, Sweeps and Corners
Tests:
  ee477FinalProject_AND_1X_1: ee477FinalProject/AND_1X/schematic, simulator spectre
    Outputs: /A; /B; /OUT
