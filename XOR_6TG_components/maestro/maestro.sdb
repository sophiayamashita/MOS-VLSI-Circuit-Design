ADE simulation setup
Run mode: Single Run, Sweeps and Corners
Tests:
  ee477FinalProject_XOR_6TG_1: ee477FinalProject/XOR_6TG_components/schematic, simulator spectre
    Outputs: /A; /B; /OUT
