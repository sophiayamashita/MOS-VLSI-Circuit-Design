ADE simulation setup
Run mode: Single Run, Sweeps and Corners
Tests:
  ee477FinalProject_XOR6TG_1: ee477FinalProject/XOR6TG/schematic, simulator spectre
    Outputs: /A; /B; /OUT
