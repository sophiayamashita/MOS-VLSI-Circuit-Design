ADE simulation setup
Run mode: Single Run, Sweeps and Corners
Tests:
  ee477FinalProject_HA_1b_1: ee477FinalProject/HA_1b/schematic, simulator spectre
    Outputs: /A; /B; /S; /C_OUT
