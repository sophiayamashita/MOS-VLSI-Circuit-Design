ADE simulation setup
Test ee477_NOT_1X_1: ee477/NOT_1X/av_extracted, simulator spectre
  Models: /home/viterbi/01/ee577/CDS_GPDK45/gpdk045_v_5_0/gpdk045/../models/spectre/gpdk045.scs[mc]
  Temperature: 27
  Stimulus vdd!: voltage dc dc=1
  Stimulus IN: voltage pulse val0=1 val1=0 period=2n rise=10p fall=10p width=1n
  Analysis tran: stop=10n
  Signals: /IN as IN, /OUT as OUT
