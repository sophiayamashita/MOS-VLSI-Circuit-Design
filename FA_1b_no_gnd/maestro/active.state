ADE simulation setup
Test ee477FinalProject_FA_1b_1: ee477FinalProject/FA_1b/schematic, simulator spectre
  Models: /home/viterbi/01/ee577/CDS_GPDK45/gpdk045_v_5_0/gpdk045/../models/spectre/gpdk045.scs[mc]
  Temperature: 27
  Stimulus A: voltage pulse val0=1 val1=0 period=8n rise=10p fall=10p width=4n
  Stimulus B: voltage pulse val0=1 val1=0 period=4n rise=10p fall=10p width=2n
  Stimulus C_IN: voltage pulse val0=1 val1=0 period=2n rise=10p fall=10p width=1n
  Stimulus vdd!: voltage dc dc=1
  Analysis tran: stop=10n
  Signals: /A, /B, /C_IN, /S, /C_OUT
