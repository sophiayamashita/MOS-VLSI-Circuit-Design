ADE simulation setup
Run mode: Single Run, Sweeps and Corners
Tests:
  ee477FinalProject_NAND_1X_1: ee477FinalProject/NAND_1X/av_extracted, simulator spectre
    Outputs: /A; /B; /OUT
