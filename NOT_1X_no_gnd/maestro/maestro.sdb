ADE simulation setup
Run mode: Single Run, Sweeps and Corners
Tests:
  ee477_NOT_1X_1: ee477/NOT_1X/av_extracted, simulator spectre
    Outputs: IN; OUT
