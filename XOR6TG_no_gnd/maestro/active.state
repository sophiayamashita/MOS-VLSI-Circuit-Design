ADE simulation setup
Test ee477FinalProject_XOR6TG_1: ee477FinalProject/XOR6TG/schematic, simulator spectre
  Models: /home/viterbi/01/ee577/CDS_GPDK45/gpdk045_v_5_0/gpdk045/../models/spectre/gpdk045.scs[mc]
  Temperature: 27
  Stimulus vdd!: voltage dc dc=1
  Stimulus A: voltage pulse val0=1 val1=0 period=2n rise=10p fall=10p width=1n
  Stimulus B: voltage pulse val0=1 val1=0 period=4n rise=10p fall=10p width=2n
  Analysis tran: stop=10n
  Signals: /A, /B, /OUT
