ADE simulation setup
Test ee477FinalProject_XOR_TG_1: ee477FinalProject/XOR_TG/schematic, simulator spectre
  Models: /home/viterbi/01/ee577/CDS_GPDK45/gpdk045_v_5_0/gpdk045/../models/spectre/gpdk045.scs[mc]
  Temperature: 27
  Analysis tran: stop=10n
Run mode: Single Run, Sweeps and Corners
