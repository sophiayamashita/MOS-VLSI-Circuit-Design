ADE simulation setup
Run mode: Single Run, Sweeps and Corners
Tests:
  ee477FinalProject_XOR_TG_1: ee477FinalProject/XOR_TG/schematic, simulator spectre
