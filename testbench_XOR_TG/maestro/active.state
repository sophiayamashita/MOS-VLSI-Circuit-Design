ADE simulation setup
Test ee477FinalProject_testbench_XOR_TG_1: ee477FinalProject/testbench_XOR_TG/schematic, simulator spectre
  Models: /home/viterbi/01/ee577/CDS_GPDK45/gpdk045_v_5_0/gpdk045/../models/spectre/gpdk045.scs[mc]
  Temperature: 27
  Stimulus vdd!: voltage dc dc=1
  Stimulus A: voltage pulse val0=0 val1=1 period=10n rise=10p fall=10p width=5n
  Stimulus B: voltage pulse val0=0 val1=1 period=3n rise=10p fall=10p width=1.5n
  Analysis tran: stop=10n
  Signals: /net7, /net1, /net5
Run mode: Single Run, Sweeps and Corners
