ADE simulation setup
Run mode: Single Run, Sweeps and Corners
Tests:
  ee477FinalProject_testbench_XOR_TG_1: ee477FinalProject/testbench_XOR_TG/schematic, simulator spectre
    Outputs: /net4; /net1; /net5; /net7
